simulator lang=spectre

// This is a generated file.
// Be careful when editing manually: this file may be overwritten.

global 0

include "/home/ff/eecs251b/sky130/sky130_cds/sky130_release_0.0.1/models/sky130.lib.spice" section=tt

simulator lang=spice

.include 'digital_ldo_core.sp'

simulator lang=spectre

*parameters Vcm=1.5 Vdiff=0.02 frequency=100K

xinst0 ( ldotop_vref ldotop_vdd 0 ldotop_clk ldotop_rst ldotop_vout nmos_subvth_b) ldo_core
xinst1  ( ldotop_vout 0 ) capacitor c=10pF
xinst2 ( ldotop_vout 0 ) isource dc=100u type=dc
*xinst2 ( vinp 0 ) vsource dc=Vcm type=sine ampl=Vdiff freq=frequency
*xinst4 ( ldotop_vref 0 ) vsource dc=Vcm type=sine ampl=-Vdiff freq=frequency
xinst10 ( nmos_subvth_b 0 ) vsource dc=2.28456 type=dc
xinst3 ( ldotop_vdd 0 ) vsource dc=1.8 mag=1
xinst4 ( ldotop_vref 0 ) vsource dc=1.5 type=dc
xinst5 ( ldotop_clk 0 ) vsource delay=0 fall=100p period=5u rise=100p type=pulse val0=1.8 val1=0 width=2.5u
xinst6 ( ldotop_rst 0) vsource type=pwl wave=[
+ 0u 1.8 9.995u 1.8
+ 10u 0 50u 0
+]

settemp1 options temp=25.0
save ldotop_vref
save ldotop_clk
save ldotop_rst
save ldotop_vout
save ldotop_vdd
saveopts options save=allpub

*precharge_Vcm sweep param=Vcm start=1.3 stop=1.5 step=0.01 {
*        analysis_0 tran stop=6u errpreset=conservative
*}

*analysis_0 tran stop=100u errpreset=conservative
*ac ac_analysis dec 100 1k 1G

simulator lang=spice
.ac dec 100 10 1G

simulator lang=spectre

// This is a generated file.
// Be careful when editing manually: this file may be overwritten.

global 0

include "/home/ff/eecs251b/sky130/sky130_cds/sky130_release_0.0.1/models/sky130.lib.spice" section=tt

simulator lang=spice

.include 'digital_ldo_core.sp'

simulator lang=spectre

parameters Vcm=1.5 Vdiff=0.02 frequency=100K

xinst0 ( ldotop_vref ldotop_vdd 0 ldotop_clk ldotop_rst ldotop_vout vdzp vdzn ) ldo_core
xinst1  ( ldotop_vout 0 ) capacitor c=1nF
*xinst2 (ldotop_vout 0) isource type=pwl wave=[
*+0u 0 4.995u 0
*+5u 7m 29.9995u 7m
*+30u 5m 39.9995u 5m
*+40u 7m 150u 7m
*+]
*xinst3 (ldotop_vout 0) isource dc=7m type=dc
xinst4 ( ldotop_vdd 0 ) vsource dc=1.8 type=dc
xinst5 ( vdzp 0 ) vsource dc=1.52 type=dc
xinst6 ( vdzn 0 ) vsource dc=1.48 type=dc
xinst7 ( ldotop_vref 0 ) vsource dc=1.5 type=dc
xinst8 (ldotop_clk 0) vsource type=pulse val0=0 val1=1.8 period=5u rise=100p fall=100p width=2.5u delay=0
xinst9 ( ldotop_rst 0) vsource type=pwl wave=[
+ 0u 1.8 4.9995u 1.8
+ 5u 0 150u 0
+]

settemp1 options temp=25.0
save ldotop_vref
save ldotop_clk
save ldotop_rst
save ldotop_vout
save ldotop_vdd
save xinst0.xinst4.comp_in
saveopts options save=allpub

*precharge_Vcm sweep param=Vcm start=1.3 stop=1.5 step=0.01 {
*        analysis_0 tran stop=6u errpreset=conservative
*}

analysis_0 tran stop=50u errpreset=conservative

simulator lang=spice

.meas tran qc avg i(xinst4)
.meas tran sa1 max i(xinst0.xinst0.MX1/X4/M0)
.meas tran sa2 max i(xinst0.xinst0.MX1/X4/M1)
.meas tran sa3 max i(xinst0.xinst0.MX1/X3/M0)
.meas tran sa4 max i(xinst0.xinst0.MX1/X3/M1)

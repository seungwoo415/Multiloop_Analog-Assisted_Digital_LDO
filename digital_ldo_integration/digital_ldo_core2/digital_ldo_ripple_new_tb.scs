simulator lang=spectre

// This is a generated file.
// Be careful when editing manually: this file may be overwritten.

global 0

include "/home/ff/eecs251b/sky130/sky130_cds/sky130_release_0.0.1/models/sky130.lib.spice" section=tt

simulator lang=spice

.include 'digital_ldo_core.sp'

simulator lang=spectre

parameters Vcm=1.5 Vdiff=0.02 frequency=100K

xinst0 ( ldotop_vref ldotop_vdd 0 ldotop_clk ldotop_rst ldotop_vout nmos_subvth_b) ldo_core
xinst1  ( ldotop_vout 0 ) capacitor c=10pF
*xinst2 ldotop_vout v1 0 0 sky130_fd_pr__nfet_01v8 l=0.15u nf=1 w=0.6u
xinst10 ( nmos_subvth_b 0 ) vsource dc=2.28456 type=dc
*xinst7 ldotop_vout vsqu 0 0 sky130_fd_pr__nfet_01v8 l=0.15u nf=1 w=0.6u
xinst12 (ldotop_vout 0) isource type=pwl wave=[
+0u 300u 49.9995u 300u
+50u 200u 94.9995u 200u
+95u 300u 150u 300u
+]
*xinst14 (ldotop_vout 0) isource dc=300u type=dc
xinst8 ( vsqu 0 ) vsource type=pwl wave=[
+0u 0 49.99995u 0
+50u 1.5V 150u 1.5V
+]
xinst3 ( ldotop_vdd 0 ) vsource dc=1.8 type=dc
xinst9 ( v1 0 ) vsource dc=1.5 type=dc
xinst4 ( ldotop_vref 0 ) vsource dc=1.5 type=dc
xinst5 (ldotop_clk 0) vsource type=pulse val0=0 val1=1.8 period=1u rise=100p fall=100p width=500n delay=0
xinst6 ( ldotop_rst 0) vsource type=pwl wave=[
+ 0u 1.8 9.995u 1.8
+ 10u 0 150u 0
+]

settemp1 options temp=25.0
save ldotop_vref
save ldotop_clk
save ldotop_rst
save ldotop_vout
save ldotop_vdd
save xinst0.xinst5
save xinst0.xinst7
save xinst12
*save I(xinst2)
saveopts options save=allpub

*precharge_Vcm sweep param=Vcm start=1.3 stop=1.5 step=0.01 {
*        analysis_0 tran stop=6u errpreset=conservative
*}

analysis_0 tran stop=150u errpreset=conservative
saveopts options save=all

simulator lang=spice
.probe I(xinst12)

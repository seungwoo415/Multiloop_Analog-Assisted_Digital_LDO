simulator lang=spectre

// This is a generated file.
// Be careful when editing manually: this file may be overwritten.

global 0

include "/home/ff/eecs251b/sky130/sky130_cds/sky130_release_0.0.1/models/sky130.lib.spice" section=tt

simulator lang=spice

.include 'digital_ldo_core_aa_assisted.sp'

simulator lang=spectre

parameters Vcm=1.5 Vdiff=0.02 frequency=100K

xinst0 ( ldotop_vref ldotop_vdd 0 ldotop_clk ldotop_rst ldotop_vout vdzp vdzn ldotop_vst ) ldo_core_aa_assisted
*xinst1  ( ldotop_vout 0 ) capacitor c=40pF
xinst2 (ldotop_vout 0) isource type=pwl wave=[
+0u 0 4.9995u 0
+5u 2.5m 19.9995u 2.5m
+20u 5m 29.9995u 5m
+30u 2.5m 40u 2.5m
+]
*xinst3 (ldotop_vout 0) isource dc=7m type=dc
xinst4 ( ldotop_vdd 0 ) vsource dc=1.8 type=dc
xinst5 ( vdzp 0 ) vsource dc=1.53 type=dc
xinst6 ( vdzn 0 ) vsource dc=1.47 type=dc
xinst7 ( ldotop_vref 0 ) vsource dc=1.5 type=dc
xinst8 (ldotop_clk 0) vsource type=pulse val0=0 val1=1.8 period=1u rise=100p fall=100p width=500n delay=0
xinst9 ( ldotop_rst 0) vsource type=pwl wave=[
+ 0u 1.8 4.9995u 1.8
+ 5u 0 40u 0
+]
xinst10 ( ldotop_vst 0) vsource type=pwl wave=[
+ 0u 1.8 16.9995u 1.8
+ 17u 0 40u 0
+]

settemp1 options temp=25.0
save ldotop_vref
save ldotop_clk
save ldotop_rst
save ldotop_vout
save ldotop_vdd
*save xinst0.xinst5
*save xinst0.xinst7
*save xinst12
*save I(xinst2)

*precharge_Vcm sweep param=C_c start=1p stop=50p step=20p {
*        analysis_0 tran stop=70u errpreset=conservative
*}

analysis_0 tran stop=40u errpreset=conservative
saveopts options save=all

simulator lang=spice

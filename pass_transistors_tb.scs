simulator lang=spectre

global 0

include "/home/ff/eecs251b/sky130/sky130_cds/sky130_release_0.0.1/models/sky130.lib.spice" section=tt

simulator lang =spice

*.include "/home/ff/eecs251b/sky130/sky130_cds/sky130_release_0.0.1/models/sky130.lib.spice" section=tt

.param W = 0.5u

V1 vdd 0 DC 1.8
V2 vs 0 DC 1.5
//I1 vs 0 DC 1u
//I2 vs 0 AC 1 0

M1 vs 0 vdd vdd sky130_fd_pr__pfet_01v8 l=0.25u nf=1 w=1.2u

*.dc W 0.5u 20.5u 0.5u

*.ac dec 100 1000 100M

*.probe ac v(vdd) i(I2) v(vs)

simulator lang=spectre

analysis_0 tran stop=20u errpreset=conservative

simulator lang=spice
.probe i(M1)
.probe v(*)
